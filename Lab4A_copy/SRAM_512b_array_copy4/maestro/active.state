ADE simulation setup
Test Lab4A_SRAM_512b_array_copy4_1: Lab4A/SRAM_512b_array_copy4/schematic, simulator spectre
  Models: /home/ee577@vlab.usc.edu/CDS_GPDK45/gpdk045_v_5_0/gpdk045/../models/spectre/gpdk045.scs[mc]
  Temperature: 27
  Files: vectors /home/tlin9034@vlab.usc.edu/work_gpdk045/sram512v2.vec
  Stimulus vdd!: voltage dc dc=1
  Stimulus VSS!: voltage dc dc=0
  Stimulus VDD!: voltage dc dc=1
  Stimulus vss!: voltage dc dc=0
  Stimulus vdd: voltage dc dc=1
  Stimulus VDD: voltage dc dc=1
  Stimulus VSS: voltage dc dc=0
  Stimulus gnd: voltage dc dc=0
  Analysis tran: stop=400n
  Signals: /data_in<15>, /data_in<14>, /data_in<13>, /data_in<12>, /data_in<11>, /data_in<10>, /data_in<9>, /data_in<8>, /data_in<7>, /data_in<6>, /data_in<5>, /data_in<4>, /data_in<3>, /data_in<2>, /data_in<1>, /data_in<0>, /data<15>, /data<14>, /data<13>, /data<12>, /data<11>, /data<10>, /data<9>, /data<8>, /data<7>, /data<6>, /data<5>, /data<4>, /data<3>, /data<2>, /data<1>, /data<0>, /data_out<15>, /data_out<14>, /data_out<13>, /data_out<12>, /data_out<11>, /data_out<10>, /data_out<9>, /data_out<8>, /data_out<7>, /data_out<6>, /data_out<5>, /data_out<4>, /data_out<3>, /data_out<2>, /data_out<1>, /data_out<0>, /A<4>, /A<3>, /A<2>, /A<1>, /A<0>, /WL<7>, /WL<6>, /WL<5>, /WL<4>, /WL<3>, /WL<2>, /WL<1>, /WL<0>, /clk, /rst, /pre_en, /read_en, /sense_en, /pre_en_SA, /W_en, /BL_B1<15>, /BL_B1<14>, /BL_B1<13>, /BL_B1<12>, /BL_B1<11>, /BL_B1<10>, /BL_B1<9>, /BL_B1<8>, /BL_B1<7>, /BL_B1<6>, /BL_B1<5>, /BL_B1<4>, /BL_B1<3>, /BL_B1<2>, /BL_B1<1>, /BL_B1<0>, /wdata<15>, /wdata<14>, /wdata<13>, /wdata<12>, /wdata<11>, /wdata<10>, /wdata<9>, /wdata<8>, /wdata<7>, /wdata<6>, /wdata<5>, /wdata<4>, /wdata<3>, /wdata<2>, /wdata<1>, /wdata<0>
Run mode: Single Run, Sweeps and Corners
