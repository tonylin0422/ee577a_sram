ADE simulation setup
Test Lab4A_SRAM_512b_array_copy3_1: Lab4A/SRAM_512b_array_copy3/schematic, simulator spectre
  Models: /home/ee577@vlab.usc.edu/CDS_GPDK45/gpdk045_v_5_0/gpdk045/../models/spectre/gpdk045.scs[mc]
  Temperature: 27
  Files: vectors /home/tlin9034@vlab.usc.edu/work_gpdk045/sram512v2.vec
  Stimulus vdd!: voltage dc dc=1
  Stimulus vss!: voltage dc dc=0
  Stimulus VSS!: voltage dc dc=0
  Stimulus VDD!: voltage dc dc=1
  Analysis tran: stop=21n
  Signals: /clk, /rst, /data<15>, /data<14>, /data<13>, /data<12>, /data<11>, /data<10>, /data<9>, /data<8>, /data<7>, /data<6>, /data<5>, /data<4>, /data<3>, /data<2>, /data<1>, /data<0>, /data_out<15>, /data_out<14>, /data_out<13>, /data_out<12>, /data_out<11>, /data_out<10>, /data_out<9>, /data_out<8>, /data_out<7>, /data_out<6>, /data_out<5>, /data_out<4>, /data_out<3>, /data_out<2>, /data_out<1>, /data_out<0>, /A<4>, /A<3>, /A<2>, /A<1>, /A<0>, /Out<15>, /Out<14>, /Out<13>, /Out<12>, /Out<11>, /Out<10>, /Out<9>, /Out<8>, /Out<7>, /Out<6>, /Out<5>, /Out<4>, /Out<3>, /Out<2>, /Out<1>, /Out<0>, /latchout<14>, /latchout<13>, /latchout<12>, /latchout<11>, /latchout<10>, /latchout<9>, /latchout<8>, /latchout<7>, /latchout<6>, /latchout<5>, /latchout<4>, /latchout<3>, /latchout<2>, /latchout<1>, /latchout<0>, /read_en, /sense_en, /pre_en_SA, /W_en, /decoder_en, /pre_en, /data_in<15>, /data_in<14>, /data_in<13>, /data_in<12>, /data_in<11>, /data_in<10>, /data_in<9>, /data_in<8>, /data_in<7>, /data_in<6>, /data_in<5>, /data_in<4>, /data_in<3>, /data_in<2>, /data_in<1>, /data_in<0>, /data_in_b<15>, /data_in_b<14>, /data_in_b<13>, /data_in_b<12>, /data_in_b<11>, /data_in_b<10>, /data_in_b<9>, /data_in_b<8>, /data_in_b<7>, /data_in_b<6>, /data_in_b<5>, /data_in_b<4>, /data_in_b<3>, /data_in_b<2>, /data_in_b<1>, /data_in_b<0>, /A_b<4>, /A_b<3>, /A_b<2>, /A_b<1>, /A_b<0>, /WL<7>, /WL<6>, /WL<5>, /WL<4>, /WL<3>, /WL<2>, /WL<1>, /WL<0>
Run mode: Single Run, Sweeps and Corners
