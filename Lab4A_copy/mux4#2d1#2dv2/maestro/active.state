ADE simulation setup
Test Lab4A_mux4-1-v2_1: Lab4A/mux4-1-v2/schematic, simulator spectre
  Models: /home/ee577@vlab.usc.edu/CDS_GPDK45/gpdk045_v_5_0/gpdk045/../models/spectre/gpdk045.scs[mc]
  Temperature: 27
  Stimulus CS3b: voltage bit rise=10p fall=10p period=1n data=0
  Stimulus CS3: voltage bit rise=10p fall=10p period=1n data=1
  Stimulus CS2b: voltage bit rise=10p fall=10p period=1n data=1
  Stimulus CS2: voltage bit rise=10p fall=10p period=1n data=0
  Stimulus CS1b: voltage bit rise=10p fall=10p period=1n data=1
  Stimulus CS1: voltage bit rise=10p fall=10p period=1n data=0
  Stimulus data_b: voltage bit rise=10p fall=10p period=1n data=1001
  Stimulus CS0b: voltage bit rise=10p fall=10p period=1n data=1
  Stimulus data: voltage bit rise=10p fall=10p period=1n data=0110
  Stimulus CS0: voltage bit rise=10p fall=10p period=1n data=0
  Stimulus vdd!: voltage dc dc=1
  Analysis tran: stop=10n
  Signals: /CS0, /CS0b, /CS1, /CS1b, /CS2, /CS2b, /CS3, /CS3b, /BL0, /BL0b, /BL1, /BL1b, /BL2, /BL2b, /BL3, /BL3b, /data, /data_b
