ADE simulation setup
Test Lab4A_SRAM_512b_array_tb_1: Lab4A/SRAM_512b_array_tb/schematic, simulator spectre
  Models: /home/ee577@vlab.usc.edu/CDS_GPDK45/gpdk045_v_5_0/gpdk045/../models/spectre/gpdk045.scs[mc]
  Temperature: 27
  Files: vectors /home/dhkwak@vlab.usc.edu/work_gpdk045/Lab4A/SRAM_512b.vec
  Stimulus clk: voltage pulse dc=1 val0=0 val1=1 period=4n delay=0 rise=10p fall=10p width=2n
  Stimulus vdd!: voltage dc dc=1
  Analysis tran: stop=85n
  Signals: /A<4:0>, /clk, /data_in<15:0>, /data_out<15:0>, /read_en, /sense_en, /pre_en_SA, /net2
Run mode: Single Run, Sweeps and Corners
