ADE simulation setup
Test Lab4A_SRAM_512b_array_copy_1: Lab4A/SRAM_512b_array_copy/schematic, simulator spectre
  Models: /home/ee577@vlab.usc.edu/CDS_GPDK45/gpdk045_v_5_0/gpdk045/../models/spectre/gpdk045.scs[mc]
  Temperature: 27
  Files: vectors /home/tlin9034@vlab.usc.edu/work_gpdk045/Lab4A/sram512.vec
  Stimulus vdd!: voltage dc dc=1
  Stimulus vss!: voltage dc dc=0
  Stimulus VSS!: voltage dc dc=0
  Stimulus VDD!: voltage dc dc=1
  Analysis tran: stop=500n
  Signals: /vdd!, /vss!, /gnd!, /clk, /rst, /pre_en, /A<4:0>, /decoder_en, /read_en, /sense_en, /pre_en_SA, /data_out<15>, /data_out<14>, /data_out<13>, /data_out<12>, /data_out<11>, /data_out<10>, /data_out<9>, /data_out<8>, /data_out<7>, /data_out<6>, /data_out<5>, /data_out<4>, /data_out<3>, /data_out<2>, /data_out<1>, /data_out<0>, /W_en, /data_in<15>, /data_in<14>, /data_in<13>, /data_in<12>, /data_in<11>, /data_in<10>, /data_in<9>, /data_in<8>, /data_in<7>, /data_in<6>, /data_in<5>, /data_in<4>, /data_in<3>, /data_in<2>, /data_in<1>, /data_in<0>, /BL<15>, /BL<14>, /BL<13>, /BL<12>, /BL<11>, /BL<10>, /BL<9>, /BL<8>, /BL<7>, /BL<6>, /BL<5>, /BL<4>, /BL<3>, /BL<2>, /BL<1>, /BL<0>, /sense<15>, /sense<14>, /sense<13>, /sense<12>, /sense<11>, /sense<10>, /sense<9>, /sense<8>, /sense<7>, /sense<6>, /sense<5>, /sense<4>, /sense<3>, /sense<2>, /sense<1>, /sense<0>, /BLb<15>, /BLb<14>, /BLb<13>, /BLb<12>, /BLb<11>, /BLb<10>, /BLb<9>, /BLb<8>, /BLb<7>, /BLb<6>, /BLb<5>, /BLb<4>, /BLb<3>, /BLb<2>, /BLb<1>, /BLb<0>, /data_b<15:0>
