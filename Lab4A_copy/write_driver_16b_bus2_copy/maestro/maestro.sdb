ADE simulation setup
Run mode: Single Run, Sweeps and Corners
Tests:
  Lab4A_write_driver_16b_bus2_copy_1: Lab4A/write_driver_16b_bus2_copy/schematic, simulator spectre
