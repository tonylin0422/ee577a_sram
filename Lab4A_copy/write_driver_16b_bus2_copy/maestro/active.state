ADE simulation setup
Test Lab4A_write_driver_16b_bus2_copy_1: Lab4A/write_driver_16b_bus2_copy/schematic, simulator spectre
  Models: /home/ee577@vlab.usc.edu/CDS_GPDK45/gpdk045_v_5_0/gpdk045/../models/spectre/gpdk045.scs[mc]
  Temperature: 27
  Files: vectors /home/tlin9034@vlab.usc.edu/work_gpdk045/Lab4A/write_driver.vec
  Stimulus vdd!: voltage dc dc=1
  Stimulus vdd: voltage dc dc=1
  Stimulus gnd: voltage dc dc=0
  Analysis tran: stop=70n
  Signals: /data<15>, /data<14>, /data<13>, /data<12>, /data<11>, /data<10>, /data<9>, /data<8>, /data<7>, /data<6>, /data<5>, /data<4>, /data<3>, /data<2>, /data<1>, /data<0>, /W_en, /BL<15>, /BL<14>, /BL<13>, /BL<12>, /BL<11>, /BL<10>, /BL<9>, /BL<8>, /BL<7>, /BL<6>, /BL<5>, /BL<4>, /BL<3>, /BL<2>, /BL<1>, /BL<0>
Run mode: Single Run, Sweeps and Corners
