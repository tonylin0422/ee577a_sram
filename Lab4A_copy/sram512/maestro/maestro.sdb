ADE simulation setup
Run mode: Single Run, Sweeps and Corners
Tests:
  Lab4A_copy_sram512_1: Lab4A_copy/sram512/schematic, simulator spectre
    Outputs: /s
