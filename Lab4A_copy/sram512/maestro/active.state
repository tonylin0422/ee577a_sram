ADE simulation setup
Test Lab4A_copy_sram512_1: Lab4A_copy/sram512/schematic, simulator spectre
  Models: /home/ee577@vlab.usc.edu/CDS_GPDK45/gpdk045_v_5_0/gpdk045/../models/spectre/gpdk045.scs[mc]
  Temperature: 27
  Files: vectors /home/tlin9034@vlab.usc.edu/work_gpdk045/sram512test.vec
  Stimulus VDD!: voltage dc dc=1
  Stimulus VSS!: voltage dc dc=0
  Stimulus RN: voltage dc dc=1
  Stimulus CLK: voltage pulse dc=1 val0=0 val1=1 period=3n delay=100p rise=5p fall=5p
  Analysis tran: stop=63n
  Signals: /data_in15, /data_in14, /data_in13, /data_in12, /data_in11, /data_in10, /data_in9, /data_in8, /data_in7, /data_in6, /data_in5, /data_in4, /data_in3, /data_in2, /data_in1, /data_in0, /data_out15, /data_out14, /data_out13, /data_out12, /data_out11, /data_out10, /data_out9, /data_out8, /data_out7, /data_out6, /data_out5, /data_out4, /data_out3, /data_out2, /data_out1, /data_out0, /decoder_en, /A0_reg, /A2_reg, /CS0b, /VDD!, /VSS!, /CLK, /RN, /pre_en, /write_en, /read_en, /sense_en, /pre_en_SA, /CS0, /wd_data_in, /wd_out, /WL7, /WL6, /WL5, /WL4, /WL3, /WL2, /WL1, /WL0
Run mode: Single Run, Sweeps and Corners
