ADE simulation setup
Test EE577a_S26_sram_1bit_tb_1: EE577a_S26/sram_1bit_tb/schematic, simulator spectre
  Models: /home/ee577@vlab.usc.edu/CDS_GPDK45/gpdk045_v_5_0/gpdk045/../models/spectre/gpdk045.scs[mc]
  Temperature: 27
  Files: vectors /home/tlin9034@vlab.usc.edu/work_gpdk045/EE577a_S26/1bit_mindelay.vec
  Stimulus VSS!: voltage dc dc=0
  Stimulus VDD!: voltage dc dc=1
  Stimulus vdd!: voltage dc dc=1
  Analysis tran: stop=2.5n
  Signals: /pre_en, /read_en, /write_enable, /write_data, /WL, /BL, /BLb, /D, /Db, /Q, /Qb
