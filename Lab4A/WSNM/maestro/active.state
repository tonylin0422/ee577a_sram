ADE simulation setup
Test EE577a_S26_WSNM_1: EE577a_S26/WSNM/schematic, simulator spectre
  Models: /home/ee577@vlab.usc.edu/CDS_GPDK45/gpdk045_v_5_0/gpdk045/../models/spectre/gpdk045.scs[mc]
  Temperature: 27
  Stimulus BLb: voltage dc dc=1
  Stimulus BL: voltage dc dc=0
  Stimulus gnd: voltage dc dc=0
  Stimulus WL: voltage dc dc=1
  Stimulus vdd: voltage dc dc=1
  Stimulus vdd!: voltage dc dc=1
  Analysis dc: sweep /V0.dc start=0 stop=1
  Signals: /Db, /D2, /Vswp
