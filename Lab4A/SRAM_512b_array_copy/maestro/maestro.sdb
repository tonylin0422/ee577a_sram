ADE simulation setup
Run mode: Single Run, Sweeps and Corners
Tests:
  Lab4A_SRAM_512b_array_copy_1: Lab4A/SRAM_512b_array_copy/schematic, simulator spectre
