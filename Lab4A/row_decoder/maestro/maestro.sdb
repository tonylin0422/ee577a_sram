ADE simulation setup
Run mode: Single Run, Sweeps and Corners
Tests:
  EE577a_S26_decoder_1: EE577a_S26/row_decoder/schematic, simulator spectre
