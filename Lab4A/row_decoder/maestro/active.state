ADE simulation setup
Test EE577a_S26_decoder_1: EE577a_S26/row_decoder/schematic, simulator spectre
  Models: /home/ee577@vlab.usc.edu/CDS_GPDK45/gpdk045_v_5_0/gpdk045/../models/spectre/gpdk045.scs[mc]
  Temperature: 27
  Stimulus A4: voltage bit rise=1p fall=1p period=1n data=00001111
  Stimulus A3: voltage bit rise=1p fall=1p period=1n data=00110011
  Stimulus A2: voltage bit rise=1p fall=1p period=1n data=01010101
  Stimulus A4b: voltage bit rise=1p fall=1p period=1n data=11110000
  Stimulus A3b: voltage bit rise=1p fall=1p period=1n data=11001100
  Stimulus A2b: voltage bit rise=1p fall=1p period=1n data=10101010
  Stimulus decoder_en: voltage dc dc=1
  Stimulus gnd!: voltage dc dc=0
  Stimulus vdd!: voltage dc dc=1
  Stimulus vdd!: voltage dc dc=1
  Analysis tran: stop=10n
  Signals: /WL0, /WL1, /WL2, /WL3, /WL4, /WL5, /WL6, /WL7
Run mode: Single Run, Sweeps and Corners
