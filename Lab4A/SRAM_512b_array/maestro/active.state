ADE simulation setup
Test Lab4A_SRAM_512b_array_1: Lab4A/SRAM_512b_array/schematic, simulator spectre
  Models: /home/ee577@vlab.usc.edu/CDS_GPDK45/gpdk045_v_5_0/gpdk045/../models/spectre/gpdk045.scs[mc]
  Temperature: 27
  Files: vectors /home/tlin9034@vlab.usc.edu/work_gpdk045/Lab4A/sram512.vec
  Stimulus vdd!: voltage dc dc=1
  Analysis tran: stop=220n
  Signals: /vdd!, /gnd!, /clk, /rst, /pre_en, /decoder_en, /W_en, /read_en, /sense_en, /pre_en_SA, /latchout<15:0>, /data_out_b<15:0>, /data_out<15:0>
Run mode: Single Run, Sweeps and Corners
