ADE simulation setup
Test Lab4A_SRAM_512b_array_copy2_1: Lab4A/SRAM_512b_array_copy2/schematic, simulator spectre
  Models: /home/ee577@vlab.usc.edu/CDS_GPDK45/gpdk045_v_5_0/gpdk045/../models/spectre/gpdk045.scs[mc]
  Temperature: 27
  Files: vectors /home/dhkwak@vlab.usc.edu/work_gpdk045/Lab4A/sram512v3.vec
  Stimulus vdd!: voltage dc dc=1
  Stimulus VSS!: voltage dc dc=0
  Stimulus VDD!: voltage dc dc=1
  Analysis tran: stop=100n
  Signals: /clk, /rst, /pre_en, /A<4:0>, /decoder_en, /read_en, /sense_en, /pre_en_SA, /W_en, /latchout<15:0>, /data<15:0>, /BL_B1<15:0>, /BLb_B1<15:0>, /sense<15:0>, /sense_b<15:0>, /data_in<15:0>, /data_out<15:0>, /WL<7:0>, /A_reg<2:0>, /A_reg_b<2:0>, /BL_B2<15:0>, /BLb_B2<15:0>, /BL_B3<15:0>, /BLb_B3<15:0>, /BL_B4<15:0>, /BLb_B4<15:0>, /data_b<15:0>, /Out<15:0>, /Out_b<15:0>, /net13<0:15>
Run mode: Single Run, Sweeps and Corners
