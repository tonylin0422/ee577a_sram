ADE simulation setup
Test Lab4A_SRAM_512b_array_copy2_1: Lab4A/SRAM_512b_array_copy2/schematic, simulator spectre
  Models: /home/ee577@vlab.usc.edu/CDS_GPDK45/gpdk045_v_5_0/gpdk045/../models/spectre/gpdk045.scs[mc]
  Temperature: 27
  Files: vectors /home/dhkwak@vlab.usc.edu/work_gpdk045/Lab4A/sram512.vec
  Stimulus vdd!: voltage dc dc=1
  Stimulus vss!: voltage dc dc=0
  Stimulus VSS!: voltage dc dc=0
  Stimulus VDD!: voltage dc dc=1
  Analysis tran: stop=500n
  Signals: /data_out<15>, /data_out<14>, /data_out<13>, /data_out<12>, /data_out<11>, /data_out<10>, /data_out<9>, /data_out<8>, /data_out<7>, /data_out<6>, /data_out<5>, /data_out<4>, /data_out<3>, /data_out<2>, /data_out<1>, /data_out<0>, /clk, /rst, /pre_en, /A<4:0>, /decoder_en, /read_en, /sense_en, /pre_en_SA, /W_en, /data_in<15>, /data_in<14>, /data_in<13>, /data_in<12>, /data_in<11>, /data_in<10>, /data_in<9>, /data_in<8>, /data_in<7>, /data_in<6>, /data_in<5>, /data_in<4>, /data_in<3>, /data_in<2>, /data_in<1>, /data_in<0>, /latchout<15:0>, /data<15:0>, /BL_B1<15:0>, /BLb_B1<15:0>, /net10<0:1>, /WL<0>, /WL<1>, /WL<2>, /WL<3>, /WL<4>, /WL<5>, /WL<6>, /WL<7>, /sense<15:0>, /sense_b<15:0>
Run mode: Single Run, Sweeps and Corners
