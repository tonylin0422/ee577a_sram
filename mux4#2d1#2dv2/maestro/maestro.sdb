ADE simulation setup
Run mode: Single Run, Sweeps and Corners
Tests:
  Lab4A_mux4-1-v2_1: Lab4A/mux4-1-v2/schematic, simulator spectre
