ADE simulation setup
Run mode: Single Run, Sweeps and Corners
Tests:
  Lab4A_row_decoder_1: Lab4A/row_decoder/schematic, simulator spectre
