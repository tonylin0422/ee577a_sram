ADE simulation setup
Test Lab4A_row_decoder_1: Lab4A/row_decoder/schematic, simulator spectre
  Models: /home/ee577@vlab.usc.edu/CDS_GPDK45/gpdk045_v_5_0/gpdk045/../models/spectre/gpdk045.scs[mc]
  Temperature: 27
  Stimulus A4: voltage bit rise=10p fall=10p period=1n data=1
  Stimulus A3: voltage bit rise=10p fall=10p period=1n data=0
  Stimulus A2: voltage bit rise=10p fall=10p period=1n data=0
  Stimulus A4b: voltage bit rise=10p fall=10p period=1n data=0
  Stimulus A3b: voltage bit rise=10p fall=10p period=1n data=1
  Stimulus A2b: voltage bit rise=10p fall=10p period=1n data=1
  Stimulus decoder_en: voltage dc dc=1
  Stimulus vdd!: voltage dc dc=1
  Analysis tran: stop=10n
  Signals: /A2, /A2b, /A3, /A3b, /A4, /A4b, /decoder_en, /WL0, /WL1, /WL2, /WL3, /WL4, /WL5, /WL6, /WL7
Run mode: Single Run, Sweeps and Corners
