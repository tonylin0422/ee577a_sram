ADE simulation setup
Run mode: Single Run, Sweeps and Corners
Tests:
  EE577a_S26_sram_1bit_tb_1: EE577a_S26/sram_1bit_tb/schematic, simulator spectre
