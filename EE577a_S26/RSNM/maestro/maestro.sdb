ADE simulation setup
Run mode: Single Run, Sweeps and Corners
Tests:
  EE577a_S26_RSNM_1: EE577a_S26/RSNM/schematic, simulator spectre
