ADE simulation setup
Run mode: Single Run, Sweeps and Corners
Tests:
  EE577a_S26_WSNM_1: EE577a_S26/WSNM/schematic, simulator spectre
